# Ansys Electronics Desktop project, version 2024.2
materials:
  vacuum: permittivity=1
  copper: permeability=0.999991 conductivity=58000000 mass_density=8933

design HFSSDesign1 (HFSS, HFSS Modal Network, model units mm)
variables:
  rotate = 0deg
geometry:
  Coil [copper] = user_primitive(SegmentedHelix/RectHelix.dll, RectHeight=3mil, RectWidth=67mil, StartHelixRadius=40mm, RadiusChange=87mil, Pitch=0mm, Turns=10, SegmentsPerTurn=36, RightHanded=1)
  Region [vacuum] = box(corner=(500mm, -500mm, 500mm), size=(-1000mm, 1000mm, -1000mm))
  Male_Head1 = component(Male_Head, 3D_Component_File_Path="<syslib>/3DComponents/HFSS/Human Body Exteriors/Male/Male_Head.a3dcomp")
  Head [humanaverage, oriented by NeckCS] = part_of(Male_Head1)
  Male_Head1.move(TranslateVectorX=0mm TranslateVectorY=0mm TranslateVectorZ=-1850mm)
  Box1 = box(corner=(61.3mm, -0.1mm, 0mm), size=(-0.3mm, 0.2mm, 0.5mm))
  Box2 = box(corner=(61mm, -0.1mm, 0.5mm), size=(-22.003168mm, 0.2mm, -0.3mm))
  Rectangle1 = rectangle(corner=(38.996832mm, 0.1mm, 0.2mm), z_size=-0.2381mm, x_size=1.7018654mm)
  Coil.unite(Box1, Box2)
  Zaxis_line = polyline((0mm, 0mm, 0mm) (0mm, 0mm, 100mm))
  Coil.rotate(axis=Z, angle=rotate)
boundaries and excitations:
  Rad1: Radiation Objects=Region
  Current1: Current Objects=Rectangle1 Direction{(39920mm, 100mm, -20mm) -> (39900mm, 100mm, 160mm)}
mesh:
  CoilMesh: LengthBased Objects=Coil MaxLength=20mm
  RegionMesh: LengthBased RefineInside Objects=Region MaxLength=200mm
  initial mesh: GlobalSurfApproximation{CurvedSurfaceApproxChoice=UseSlider SliderMeshSettings=1}
setups:
  Setup1: HfssDriven Frequency=300kHz MaxDeltaE=0.1 MaximumPasses=10 MinimumPasses=5 MinimumConvergedPasses=1 PercentRefinement=30 BasisOrder=1 DrivenSolverType="Iterative Solver" IterativeResidual=1e-06 DDMSolverResidual=0.0001 ExpressionCache{CacheItem{Title=Mag_E1 Expression=Mag_E Intrinsics="Phase='0deg' NormalizedDistance='0'" IsConvergence UseRelativeConvergence=1 MaxConvergenceDelta=5 MaxConvergeValue=1V_per_meter TraceID=82 ReportType=5}} ConstantDelta=0s
source amplitudes:
  Current1:1: 1A 0deg
optimetrics:
  ParametricSetup1: Parametric Sim._Setups=[Setup1]
    sweep rotate: LIN 0deg 360deg 90deg
    table edits: del(360deg)
    calculate MaxAvgSAR on Setup1 : LastAdaptive at Freq 0.0003GHz, Phase 0deg
field calculator expressions:
  PeakE = Fundamental_Quantity(0) | Smooth | CmplxPeak
  MaxAvgSAR = Fundamental_Quantity(2) | EnterVolume(Head) | VolumeValue | Maximum
field plots:
  Mag_E1: E Field over a plane on Setup1 : LastAdaptive at Freq=0.0003GHz Phase=0deg
  Mag_H1: H Field over a plane on Setup1 : LastAdaptive at Freq=0.0003GHz Phase=0deg
  Average_SAR1: SAR Field in Head on Setup1 : LastAdaptive at Freq=0.0003GHz Phase=0deg
reports:
  Calculator Expressions Plot 1: MaxAvgSAR vs rotate on Setup1 : LastAdaptive [Phase=0deg Freq=0.0003GHz]
  Calculator Expressions Table 1: MaxAvgSAR vs rotate on Setup1 : LastAdaptive [Phase=0deg Freq=0.0003GHz]
  Plot 1: Mag_E vs Distance on Setup1 : LastAdaptive [Freq=0.0003GHz Phase=0deg rotate=all]
